* Parameters the MC simulation of the Bubk converter netlist

.PARAM PR_RL=0.0094527
.PARAM PR_R2=12380.685
.PARAM PC_cout=4.6398e-05
.PARAM PV_Vd=0.67556
.PARAM PR_Rc=0.02126
.PARAM PC_C3=4.9982e-09
.PARAM PL_L1=4.7985e-05
.PARAM PR_R1=10189.4252
.PARAM PR_R3=195.5237
.PARAM PV_Vin=12
.PARAM PR_R27=1.3053
.PARAM PV_Vref=2.4709
.PARAM PR_R36=974.3212
.PARAM PR_R35=968.1062
.PARAM PC_C2=2.6276e-11
.PARAM PC_C1=3.8914e-09
.PARAM PR_Ron=0.29631
