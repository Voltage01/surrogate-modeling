* Parameters for differential-amplifier AC simulation

.PARAM PR_C1=4495.05394775557
.PARAM PR_C2=4241.79292340729
.PARAM PV_VS=5
.PARAM PI_S=0.00107494138759192
.PARAM PV_Vin_1_amp=1
.PARAM PV_Vin_1_phase=0
.PARAM PV_Vin_2_amp=1
.PARAM PV_Vin_2_phase=0
