* Netlist of a basic differential amplifier model as a test case for VV-KRR.

.INCLUDE DIFFERENTIAL_PARAMS.cir
.options gmin = 1e-10
.options abstol = 1e-10
.options reltol = 0.003

* Circuit Topology
V_Vp 1 0 {PV_VS}
V_Vn 0 7 {PV_VS}

R_C1 1 2 {PR_C1}
R_C2 1 3 {PR_C2}

Q1 2 4 6 Q2N3904
Q2 3 5 6 Q2N3904

I_S 6 7 {PI_S}

V_Vin_1 4 0 DC 0 AC {PV_Vin_1_amp} {PV_Vin_1_phase}
V_Vin_2 5 0 DC 0 AC {PV_Vin_2_amp} {PV_Vin_2_phase}

.model Q2N3904 NPN(Is=6.734f Xti=3 Eg=1.11 Vaf=74.03 Bf=416.4
+ Ne=1.259 Ise=6.734f Ikf=66.78m Xtb=1.5 Br=0.7371 Nc=2
+ Isc=0 Ikr=0 Rc=1 Cjc=3.638p Mjc=0.3085 Vjc=0.75 Fc=0.5
+ Cje=4.493p Mje=0.2593 Vje=0.75 Tr=239.5n Tf=301.2p
+ Itf=0.4 Vtf=4 Xtf=2 Rb=10)

* Analysis Block
.ac dec 50 10 10Meg

* Output
.probe V(2)
.probe V(3)

.end
